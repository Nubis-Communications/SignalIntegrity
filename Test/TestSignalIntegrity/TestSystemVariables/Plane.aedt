# Ansys Electronics Desktop project, version 2022.2
materials:
  air: permittivity=1.0006 permeability=1.0000004
  vacuum: permittivity=1
  pec: conductivity=1e+30
  copper: permeability=0.999991 conductivity=58000000
  FR4_epoxy: permittivity=4.4 dielectric_loss_tangent=0.02

design HFSSDesign1 (HFSS, DrivenTerminal, model units mm)
options: Allow_Material_Override Calculate_Lossy_Dielectrics Save_Adaptive_support_files
geometry:
  Power [copper] = imported_body()
  airbox [air] = imported_body()
  fill [FR4_epoxy] = imported_body()
  ground [copper] = imported_body()
  airbox.move_faces(MoveAlongNormalFlag=false MoveVectorX=-2.3475mm MoveVectorY=-2.3475mm MoveVectorZ=-0.3mm FacesToMove=?.face(#67))
  fill.move_faces(MoveAlongNormalFlag=false MoveVectorX=-0.075mm MoveVectorY=-0.075mm MoveVectorZ=4.4408921e-16mm FacesToMove=?.face(#94))
  airbox.move_faces(MoveAlongNormalFlag=false MoveVectorX=2.3475mm MoveVectorY=-2.3475mm MoveVectorZ=-0.3mm FacesToMove=?.face(#69))
  fill.move_faces(MoveAlongNormalFlag=false MoveVectorX=0.075mm MoveVectorY=0.075mm MoveVectorZ=0mm FacesToMove=?.face(#96))
  fill.move_faces(MoveAlongNormalFlag=false MoveVectorX=0mm MoveVectorY=-0.075mm MoveVectorZ=4.4408921e-16mm FacesToMove=?.face(#97))
  fill.move_faces(MoveAlongNormalFlag=false MoveVectorX=0mm MoveVectorY=0.075mm MoveVectorZ=3.469447e-18mm FacesToMove=?.face(#95))
  Rectangle1 [pec] = rectangle(corner=(0mm, 0mm, 0.02mm), y_size=2mm, z_size=0.3mm)
  Rectangle2 [pec] = rectangle(corner=(15mm, 0mm, 0.02mm), y_size=2mm, z_size=0.3mm)
  Power.move_faces(MoveAlongNormalFlag=false MoveVectorX=0mm MoveVectorY=0mm MoveVectorZ=-0.12mm FacesToMove=?.face(#13))
  Rectangle1.thicken(-0.01mm)
  Rectangle2.thicken(0.01mm)
  Rectangle2.move_faces(MoveAlongNormalFlag=true OffsetDistance=1mm FacesToMove=Rectangle2.face(#336))
  Rectangle2.move_faces(MoveAlongNormalFlag=true OffsetDistance=1mm FacesToMove=Rectangle2.face(#338))
  Rectangle1.move_faces(MoveAlongNormalFlag=true OffsetDistance=1mm FacesToMove=Rectangle1.face(#311))
  Rectangle1.move_faces(MoveAlongNormalFlag=true OffsetDistance=1mm FacesToMove=Rectangle1.face(#309))
boundaries and excitations:
  airbox_RAD: Radiation Objects=airbox
  Power_T1: Terminal port=1 Faces=?.face(#13) TerminalResistance=50ohm
  Power_T2: Terminal port=2 Faces=?.face(#15) TerminalResistance=50ohm
  1: Wave Port Faces=Rectangle2.face(#334) NumModes=1
  2: Wave Port Faces=Rectangle1.face(#307) NumModes=1
  reference conductors: Rectangle1, ground
mesh:
  initial mesh: MeshMethod=AnsoftClassic
setups:
  Setup1: HfssDriven Frequency=1GHz MaxDeltaS=0.0001 MaximumPasses=50 MinimumPasses=1 MinimumConvergedPasses=1 PercentRefinement=30 BasisOrder=-1 Target=0.666667 PortAccuracy=2 DrivenSolverType="Direct Solver" SaveAnyFields=false
    sweep Sweep1: 1Hz to 1GHz, log, 100 per decade; Type=Interpolating SaveFields InterpTolerance=0.5 InterpMaxSolns=250 PassivityErrorTolerance=0.0001
source amplitudes:
  1:1: 1V 0deg
  2:1: 0V 0deg
